# Ansys Electronics Desktop project, version 2022.2
materials:
  vacuum: permittivity=1

design HFSSDesign1 (HFSS, DrivenTerminal, model units in)
geometry:
  waveguide [vacuum] = box(corner=(-0.795in, -0.3975in, 0in), size=(1.59in, 0.795in, 1in))
  face = rectangle(corner=(-3.975in, -1.9875in, 5in), x_size=7.95in, y_size=3.975in)
  waveguide_ObjectFromFace1 = object_from(waveguide.face(+z))
  face_ObjectFromFace1 = object_from(face.face(at (0, 0, 5)))
  waveguide_ObjectFromFace1.connect(face_ObjectFromFace1)
  waveguide_ObjectFromFace1.uncover_faces(FacesToUncover=face_ObjectFromFace1.face)
  face.uncover_faces(FacesToUncover=face.face(at (0, 0, 5)))
  waveguide_ObjectFromFace1.uncover_faces(FacesToUncover=waveguide.face(1 of 1))
  waveguide.uncover_faces(FacesToUncover=waveguide.face(+z))
  waveguide.unite(waveguide_ObjectFromFace1)
